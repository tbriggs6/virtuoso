ADE simulation setup
Test ship_cells_test:INVX1_test1:1: ship_cells_test/INVX1_test1/config, simulator ams
  Models: /opt/uofu/ELC/ami06.scs
  Temperature: 27
  Analysis tran: stop=40u
  Signals: /x, /y, /ay, /ax
Run mode: Single Run, Sweeps and Corners
