ADE simulation setup
Run mode: Single Run, Sweeps and Corners
Tests:
  ship_cells_test:INVX1_test1:1: ship_cells_test/INVX1_test1/config, simulator ams
