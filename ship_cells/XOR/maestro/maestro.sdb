ADE simulation setup
Run mode: Single Run, Sweeps and Corners
Tests:
  ship_cells:XOR:1: ship_cells/XOR/schematic, simulator spectre
