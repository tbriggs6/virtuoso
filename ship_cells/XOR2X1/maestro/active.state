ADE simulation setup
Test ship_cells:XOR2X1:1: ship_cells/XOR2X1/schematic, simulator spectre
  Models: /opt/uofu/ELC/ami06.scs
  Temperature: 27
  Stimulus vdd!: voltage dc dc=5
  Stimulus B: voltage bit val1=5 val0=0 delay=0 rise=1p fall=1p period=10u data=01 rpttimes=2
  Stimulus A: voltage bit val1=5 val0=0 delay=0 rise=1p fall=1p period=20u data=01
  Analysis tran: stop=40u
  Signals: /A, /B, /Y
Run mode: Single Run, Sweeps and Corners
