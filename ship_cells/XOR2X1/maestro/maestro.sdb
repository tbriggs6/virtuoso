ADE simulation setup
Run mode: Single Run, Sweeps and Corners
Tests:
  ship_cells:XOR2X1:1: ship_cells/XOR2X1/schematic, simulator spectre
