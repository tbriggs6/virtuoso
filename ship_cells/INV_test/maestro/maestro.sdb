ADE simulation setup
Run mode: Single Run, Sweeps and Corners
Tests:
  ship_cells:INV_test:1: ship_cells/INV_test/config, simulator spectre
