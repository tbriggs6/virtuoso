ADE simulation setup
Test ship_cells:INV_test:1: ship_cells/INV_test/config, simulator spectre
  Models: /opt/uofu/ELC/ami06.scs
  Temperature: 27
  Stimulus vdd!: voltage dc dc=5
  Stimulus In: voltage bit val1=5 val0=0 delay=0 rise=1p fall=1p period=10u data=101
  Analysis tran: stop=80u
  Signals: /In, /net4, /net3
Run mode: Single Run, Sweeps and Corners
