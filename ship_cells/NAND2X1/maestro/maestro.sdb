ADE simulation setup
Run mode: Single Run, Sweeps and Corners
Tests:
  ship_cells:NAND2X1:1: ship_cells/NAND2X1/schematic, simulator spectre
