ADE simulation setup
Test ship_cells:TGATE:1: ship_cells/TGATE/schematic, simulator spectre
  Models: /opt/uofu/ELC/ami06.scs
  Temperature: 27
  Stimulus B: voltage bit val1=5 val0=0 delay=0 rise=1p fall=1p period=10u data=0101
  Stimulus An: voltage bit val1=5 val0=0 delay=0 rise=1p fall=1p period=20u data=01
  Stimulus A: voltage bit val1=5 val0=0 delay=0 rise=1p fall=1p period=20u data=10
  Analysis tran: stop=50u
  Signals: /A, /B, /An, /Y
Run mode: Single Run, Sweeps and Corners
