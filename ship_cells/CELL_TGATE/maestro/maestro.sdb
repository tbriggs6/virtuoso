ADE simulation setup
Run mode: Single Run, Sweeps and Corners
Tests:
  ship_cells:TGATE:1: ship_cells/TGATE/schematic, simulator spectre
